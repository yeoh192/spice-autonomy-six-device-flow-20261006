Declarative SPICE workflow circuit
.options plotwinsize=0
.temp 25
.options method=trap
.include "model.lib"
XDUT COMP VFB ISENSE RTCT 0 OUTPUT VCC VREF UC2845
VCCSUP VCC 0 15
VFBSET VFB 0 2.5
VSENSE ISENSE 0 0
IREFLOAD VREF 0 0.001
CVCC VCC 0 9.9999999999999995e-08
CVREF VREF 0 9.9999999999999995e-08
RRT VREF RTCT 10000
CCT RTCT 0 3.3000000000000002e-09
VDUMMY UNUSED 0 0
.dc VDUMMY 0 1 1
.save i(vfbset)
.end
