Declarative SPICE workflow circuit
.options plotwinsize=0
.temp 25
.options method=trap
.include "model.lib"
XDUT COMP VFB ISENSE RTCT 0 OUTPUT VCC VREF UC2845
VCCSUP VCC 0 15
VFBSET VFB 0 0
VSENSE ISENSE 0 PWL(0 0 4.0000000000000003e-05 0 4.002e-05 2 6.0000000000000002e-05 2)
IREFLOAD VREF 0 0.001
CVCC VCC 0 9.9999999999999995e-08
CVREF VREF 0 9.9999999999999995e-08
RRT VREF RTCT 10000
CCT RTCT 0 3.3000000000000002e-09
VCOMPSET COMP 0 5
COUTPUT OUTPUT 0 1.0000000000000001e-09
.tran 0 6.0000000000000002e-05 0 2.0000000000000001e-09
.save v(isense) v(output) v(vref)
.end
