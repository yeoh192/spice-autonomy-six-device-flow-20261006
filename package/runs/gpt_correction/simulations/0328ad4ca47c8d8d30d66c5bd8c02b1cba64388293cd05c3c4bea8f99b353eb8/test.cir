Declarative SPICE workflow circuit
.options plotwinsize=0
.temp 25
.options method=trap
VORACLE SECP SECN 0.40000000000000002
VCM SECN 0 0.29999999999999999
VDUMMY ORACLE_DUMMY 0 0
.dc VDUMMY -0.98999999999999999 1.01 0.10000000000000001
.save v(secn) v(secp)
.end
