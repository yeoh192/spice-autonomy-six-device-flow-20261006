Declarative SPICE workflow circuit
.options plotwinsize=0
.temp 25
.options method=trap
VCAL P 0 0 AC 0.59999999999999998
RCAL P M 1000
CCAL M 0 1.9999999999999999e-06
.ac lin 1 1000 1000
.save i(vcal) v(p)
.end
