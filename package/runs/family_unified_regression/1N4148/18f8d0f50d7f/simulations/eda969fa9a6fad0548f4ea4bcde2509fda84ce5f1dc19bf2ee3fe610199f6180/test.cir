Declarative SPICE workflow circuit
.options plotwinsize=0
.temp 25
.options method=trap
.include "model.lib"
XDUT P 0 LEAKAGE_FITTED_1N4148
VREVERSE P 0 -20
VDUMMY UNUSED 0 0
.dc VDUMMY 0 1 1
.save i(vreverse)
.end
