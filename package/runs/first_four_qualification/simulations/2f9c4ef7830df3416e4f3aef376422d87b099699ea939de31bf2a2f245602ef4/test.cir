Declarative SPICE workflow circuit
.options plotwinsize=0
.temp 25
.options method=trap
.include "model.lib"
XDUT D G 0 BUK7K52-60E
VD D 0 5
VG G 0 3
VSCAN UNUSED 0 0
.dc VSCAN 0 1 1
.save i(vd)
.end
