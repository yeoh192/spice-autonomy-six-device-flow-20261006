Declarative SPICE workflow circuit
.options plotwinsize=0
.temp 25
.options method=trap
.include "model.lib"
XDUT P 0 LEAKAGE_FITTED_1N4148
VAC P 0 -9.9079898049999997 AC 1
.ac lin 1 1000000 1000000
.save i(vac)
.end
