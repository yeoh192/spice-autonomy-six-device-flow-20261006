Declarative SPICE workflow circuit
.options plotwinsize=0
.temp 25
.options method=trap
RCAL Q 0 1000
VG P 0 0
vd Q P 0
.dc VG 3.7543286849999999 6.2871555289999996 0.0012664134219999999
.save i(vd)
.end
