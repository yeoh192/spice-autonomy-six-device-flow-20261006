Declarative SPICE workflow circuit
.options plotwinsize=0
.temp 25
.options method=trap
vg ORACLE_P 0 0
IORACLE 0 ORACLE_P 0.00040000000000000002
VORACLE_SCAN ORACLE_SCAN 0 0
.dc VORACLE_SCAN -1 1 0.10000000000000001
.save i(vg)
.end
