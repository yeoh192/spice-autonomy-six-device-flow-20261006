Declarative SPICE workflow circuit
.options plotwinsize=0
.temp 20
.options method=trap
.include "model.lib"
XDUT P20 0 PCOLD 0 COMPARISON_CAP
VROOM P20 0 0 AC 0.10000000000000001
VCOLD PCOLD 0 0 AC 0.10000000000000001
.ac lin 1 120 120
.save i(vcold) i(vroom)
.end
