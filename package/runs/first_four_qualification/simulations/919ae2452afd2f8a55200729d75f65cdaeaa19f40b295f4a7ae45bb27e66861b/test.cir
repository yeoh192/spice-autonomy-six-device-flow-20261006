Declarative SPICE workflow circuit
.options plotwinsize=0
.temp 175
.options method=trap
RCAL Q 0 2000
VG P 0 0
vd Q P 0
.dc VG 3.2966837870000001 6.4336896430000001 0.001568502928
.save i(vd)
.end
