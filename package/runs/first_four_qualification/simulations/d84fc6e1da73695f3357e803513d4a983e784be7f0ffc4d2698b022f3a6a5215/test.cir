Declarative SPICE workflow circuit
.options plotwinsize=0
.temp 25
.options method=trap
VORACLE s 0 0.40000000000000002
VDUMMY ORACLE_DUMMY 0 0
.dc VDUMMY 4 6 0.10000000000000001
.save v(s)
.end
