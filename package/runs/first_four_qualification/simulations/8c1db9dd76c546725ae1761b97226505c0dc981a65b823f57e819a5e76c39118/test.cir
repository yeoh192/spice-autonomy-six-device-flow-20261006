Declarative SPICE workflow circuit
.options plotwinsize=0
.temp 25
.options method=trap
.include "model.lib"
XDUT D G 0 BUK7K52-60E
VD D 0 0
VG G 0 20
VDUMMY UNUSED 0 0
.dc VDUMMY 0 1 1
.save i(vg)
.end
