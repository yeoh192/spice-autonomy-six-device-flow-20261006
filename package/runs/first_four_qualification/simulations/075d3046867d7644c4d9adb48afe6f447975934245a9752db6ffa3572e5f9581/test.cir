Declarative SPICE workflow circuit
.options plotwinsize=0
.temp 25
.options method=trap
VORACLE d 0 0.80000000000000004
VDUMMY ORACLE_DUMMY 0 0
.dc VDUMMY -0.999 1.0009999999999999 0.10000000000000001
.save v(d)
.end
