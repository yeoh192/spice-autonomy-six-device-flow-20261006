Declarative SPICE workflow circuit
.options plotwinsize=0
.temp 25
.options method=trap
.include "model.lib"
XDUT D G 0 BUK7K52-60E
VG G 0 10
VD D 0 0
.dc VD 0 0.81150541620000005 0.00040575270810000002
.save i(vd)
.end
