Declarative SPICE workflow circuit
.options plotwinsize=0
.temp 125
.options method=trap
.include "model.lib"
XDUT IP 0 0 VCC OUT 0 REFERENCE_INTERFACE
VSUP VCC 0 5
IFORCE 0 IP 0
VDUMMY UNUSED 0 0
.dc IFORCE -20 20 1
.save v(out)
.end
