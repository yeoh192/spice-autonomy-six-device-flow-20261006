Declarative SPICE workflow circuit
.options plotwinsize=0
.temp 75
.options method=trap
.include "model.lib"
XDUT IP 0 0 VCC OUT 0 REFERENCE_INTERFACE
VSUP VCC 0 5
IFORCE 0 IP 0
VDUMMY UNUSED 0 0
VZERO ZERO 0 2.5
.dc VDUMMY 0 1 1
.save v(out) v(zero)
.end
