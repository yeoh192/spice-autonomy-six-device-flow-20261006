Declarative SPICE workflow circuit
.options plotwinsize=0
.temp 25
.options method=trap
.include "model.lib"
XDUT IP 0 0 VCC OUT 0 REFERENCE_INTERFACE
VSUP VCC 0 4.5
VDUMMY UNUSED 0 0
IFORCE 0 IP 0
.dc VDUMMY 0 1 1
.save i(vsup)
.end
