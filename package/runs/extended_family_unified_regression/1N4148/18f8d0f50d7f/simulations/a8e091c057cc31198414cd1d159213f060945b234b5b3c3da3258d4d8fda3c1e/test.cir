Declarative SPICE workflow circuit
.options plotwinsize=0
.temp 25
.options method=trap
.include "model.lib"
XDUT P 0 LEAKAGE_FITTED_1N4148
IFORCE 0 P 0
.dc IFORCE 0 0.02 0.001
.save v(p)
.end
