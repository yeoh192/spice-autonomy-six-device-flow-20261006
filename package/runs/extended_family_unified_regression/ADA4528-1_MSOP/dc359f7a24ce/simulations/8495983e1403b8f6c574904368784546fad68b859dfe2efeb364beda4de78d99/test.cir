Declarative SPICE workflow circuit
.options plotwinsize=0
.temp -40
.options method=trap
.include "model.lib"
XDUT IP IM VCC 0 OUT REFERENCE_INTERFACE
VSUP VCC 0 5
VCM CM 0 2.5
VDUMMY UNUSED 0 0
VIP CM IP 0
VIM CM IM 0
.dc VDUMMY 0 1 1
.save i(vim) i(vip)
.end
