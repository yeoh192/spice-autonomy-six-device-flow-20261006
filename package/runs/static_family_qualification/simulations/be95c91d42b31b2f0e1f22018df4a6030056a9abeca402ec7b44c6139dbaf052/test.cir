Declarative SPICE workflow circuit
.options plotwinsize=0
.temp 125
.options method=trap
.include "model.lib"
XDUT IN OUT VCC 0 OUT REFERENCE_INTERFACE
VSUP VCC 0 5
VDUMMY UNUSED 0 0
VCM IN 0 2.5
.dc VDUMMY 0 1 1
.save i(vsup)
.end
