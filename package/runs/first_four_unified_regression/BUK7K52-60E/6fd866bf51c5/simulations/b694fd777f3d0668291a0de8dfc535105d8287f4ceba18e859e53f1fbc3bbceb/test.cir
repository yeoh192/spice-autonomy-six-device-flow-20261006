Declarative SPICE workflow circuit
.options plotwinsize=0
.temp 25
.options method=trap
.include "model.lib"
XDUT D G 0 BUK7K52-60E
VG G 0 0
VD D 0 10
.dc VG 3.7543286849999999 6.2871555289999996 0.0012664134219999999
.save i(vd)
.end
