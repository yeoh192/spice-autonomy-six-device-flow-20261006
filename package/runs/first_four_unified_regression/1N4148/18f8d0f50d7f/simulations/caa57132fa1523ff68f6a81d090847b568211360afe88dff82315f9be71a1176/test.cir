Declarative SPICE workflow circuit
.options plotwinsize=0
.temp 25
.options method=trap
.include "model.lib"
XDUT A 0 LEAKAGE_FITTED_1N4148
VSW DRIVE 0 PWL(0 1.741494841604204 1.9999999999999999e-07 1.741494841604204 2.001e-07 -5.2585051583957956 4.9999999999999998e-07 -5.2585051583957956)
RLOAD DRIVE PROBE 100
VSENSE PROBE A 0
.tran 0 4.9999999999999998e-07 0 9.9999999999999994e-12
.save i(vsense)
.end
