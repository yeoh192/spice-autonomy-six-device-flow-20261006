Declarative SPICE workflow circuit
.options plotwinsize=0
.temp 20
.options method=trap
.include "model.lib"
XDUT P N AUXP AUXN SECP SECN REFERENCE_XFMR
VDRIVE P N 0 AC 0.10000000000000001
RGROUND N 0 9.9999999999999995e-07
RAUX AUXN 0 9.9999999999999995e-07
RSEC SECN 0 9.9999999999999995e-07
.ac lin 1 10000 10000
.save v(n) v(p) v(secn) v(secp)
.end
